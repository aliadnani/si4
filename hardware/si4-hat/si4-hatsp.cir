.title KiCad schematic
J4 __J4
C14 +2V5 GND 1u
J5 __J5
LS1 Net-_U1-SPKR_OUTA-_ Net-_U1-SPKR_OUTA+_ Speaker
C12 +5V GND 1u
C11 Net-_U1--VHPFILT_ GND 1u
U2 __U2
C21 +2V5 GND 1u
R1 Net-_J1-Pad2_ Net-_U1-HP/LINE_OUTA_ 51.1
R5 Net-_U1-MICBIAS_ Net-_C7-Pad1_ 2.2k
C5 Net-_U1-HP/LINE_OUTB_ GND 0.022u
C4 Net-_U1-HP/LINE_OUTA_ GND 0.022u
C24 +3V3 GND 0.1u
C6 +2V5 GND 0.1u
C8 +5V GND 1u
C9 +5V GND 10u
C13 +2V5 GND 0.1u
R2 Net-_U1-HP/LINE_OUTB_ Net-_J1-Pad3_ 51.1
J1 __J1
U1 __U1
C2 Net-_U1-MICBIAS_ GND 1u
C10 Net-_U1-FLYN_ Net-_U1-FLYP_ 1u
C3 Net-_U1-VQ_ GND 1u
C1 Net-_U1-FILT+_ GND 10u
R12 /MISO +3V3 10k
R9 /MOSI +3V3 10k
R8 Net-_J3-DAT1_ +3V3 10k
R10 /SCL_SPI +3V3 10k
R7 /CS_SD +3V3 10k
R3 Net-_C7-Pad1_ GND 100k
C17 Net-_C17-Pad1_ Net-_U1-AIN4B/MIC2+/MIC2B_ 1u
R6 Net-_C17-Pad1_ GND 100k
R4 Net-_U1-MICBIAS_ Net-_C17-Pad1_ 2.2k
C7 Net-_C7-Pad1_ Net-_U1-AIN4A/MIC1+/MIC2A_ 1u
J2 __J2
R11 Net-_J3-DAT2_ +3V3 10k
J3 __J3
C23 +3V3 GND 1u
C15 GND Net-_U1-AIN3B/MIC2-/MIC1B_ 1u
C25 +2V5 GND 0.1u
C19 +3V3 GND 0.1u
C18 Net-_U1-AFILTB_ GND 150p
C20 Net-_U1-AFILTA_ GND 150p
C22 +2V5 GND 1u
C16 GND Net-_U1-AIN3A/MIC1-/MIC1A_ 1u
.end
